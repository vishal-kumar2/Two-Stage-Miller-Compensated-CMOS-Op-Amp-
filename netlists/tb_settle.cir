* Unity-gain follower, 100 mV step -> settling time, overshoot
.include corner.inc
.include models.lib
.include opamp.cir
Vdd vdd 0 {vdd_val}
Iref vdd ibias 20u
Vin inp 0 PWL(0 0.85 100n 0.85 100.1n 0.95 1u 0.95)
XU1 inp out out vdd 0 ibias opamp
CL out 0 2p
.control
tran 0.2n 1u
wrdata ../results/tran_settle.dat v(inp) v(out)
.endc
.end
