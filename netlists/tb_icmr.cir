* Open-loop response vs input common-mode voltage -> ICMR (UGF within 10% of mid-supply value)
.include corner.inc
.include models.lib
.include opamp.cir
Vdd vdd 0 {vdd_val}
Iref vdd ibias 20u
Vcm cm 0 0.9
Vin inp cm dc 0 ac 1
Lfb out inn 1G
Cfb inn 0 1G
XU1 inp inn out vdd 0 ibias opamp
CL out 0 2p
.control
set appendwrite
shell rm -f ../results/icmr_gain.dat
foreach v 0.30 0.35 0.40 0.45 0.50 0.55 0.60 0.65 0.70 0.75 0.80 0.85 0.90 0.95 1.00 1.05 1.10 1.15 1.20 1.25 1.30 1.35 1.40 1.45 1.50 1.55 1.60 1.65 1.70 1.75
  alter Vcm dc = $v
  ac dec 10 1 1G
  wrdata ../results/icmr_gain.dat v(out)
end
.endc
.end
